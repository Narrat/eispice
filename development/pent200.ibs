[IBIS Ver]   2.1
[File name]   pent200.ibs
[File Rev]   2.2
[Date]   5/24/96
[Source]   Intel Corp.
[Notes]
1. Data for these models was extracted using a buffer/package model
   combination (i.e. effects of the package on the VCC and VSS
   connections to the buffer are accounted for in the model data).
2. The maximum model represents a single output switching.  The minimum
   model respresents multiple outputs switching.
3. For meaningful simulation results, the target simulator
   MUST provide support for non-linear output waveforms; i.e.
   it must use the data in the [Falling waveform] tables.
4. Refer to the accompanying README file for information regarding how
   to properly model the package stub.  Lumped L, R and C values
   should NOT be used.
5. The min (slow corner) GTL+ I/V data has been adjusted to reflect the
   0.6v @ 36ma max specification of the GTL+ bus, as stated in the
   Pentium(R) Pro Processor Data Book.  This model represents only
   the Pentium Pro Processor at 180/200Mhz.
[Disclaimer]   Data is for modeling purposes only and is not guaranteed
[Copyright]   Copyright 1996 by Intel Corp.
[Component]   Pentium(R)_Pro_Processor
[Manufacturer] Intel Corp.
[Package]
|   The Pentium Pro processor package stubs are NOT modeled
|   using lumped L/R/C parameters.  Refer to the accompanying
|   packaging files for information on package stub (pin)
|   modeling.
|   typ   min   max
R_pkg   0.0   0.0   0.0
L_pkg   0.0   0.0   0.0
C_pkg   0.0   0.0   0.0
[Pin]  signal_name   model_name
A1   VREF0   NC
A3   STPCLK#   CMOS_IN
A5   TCK   CMOS_IN
A7   TRST#   CMOS_IN
A9   IGNNE#   CMOS_IN
A11   A20M#   CMOS_IN
A13   TDI   CMOS_IN
A15   FLUSH#   CMOS_IN
A17   THERMTRIP#   CMOS_OUT
A19   BCLK   CLKBUFF
A21   RESERVED   NC
A23   TESTHI   NC
A25   TESTHI   NC
A27   D1#   GTL_I/O
A29   D3#   GTL_I/O
A31   D5#   GTL_I/O
A33   D8#   GTL_I/O
A35   D9#   GTL_I/O
A37   D14#   GTL_I/O
A39   D10#   GTL_I/O
A41   D11#   GTL_I/O
A43   D13#   GTL_I/O
A45   D16#   GTL_I/O
A47   VREF4   NC
B2   EMI   POWER
B4   VCCP   POWER
B6   VSS   GND
B8   VCCP   POWER
B12   VSS   GND
B16   VCCP   POWER
B20   VSS   GND
B24   VCCP   POWER
B28   VSS   GND
B32   VCCP   POWER
B36   VSS   GND
B40   VCCP   POWER
B42   VSS   GND
B44   VCCP   POWER
B46   EMI   POWER
C1   A35#   GTL_I/O
C3   IERR#   CMOS_OUT
C5   BERR#   GTL_I/O
C7   VREF1   NC
C9   FRCERR   GTL_I/O
C11   INIT#   CMOS_IN
C13   TDO   CMOS_OUT
C15   TMS   CMOS_IN
C17   FERR#   CMOS_OUT
C19   PLL1   NC
C21   TESTLO   NC
C23   PLL2   NC
C25   D0#   GTL_I/O
C27   D2#   GTL_I/O
C29   D4#   GTL_I/O
C31   D6#   GTL_I/O
C33   D7#   GTL_I/O
C35   D12#   GTL_I/O
C37   D15#   GTL_I/O
C39   D17#   GTL_I/O
C41   D20#   GTL_I/O
C43   D18#   GTL_I/O
C45   D19#   GTL_I/O
C47   D21#   GTL_I/O
E1   A29#   GTL_I/O
E3   A30#   GTL_I/O
E5   A32#   GTL_I/O
E7   A33#   GTL_I/O
E9   A34#   GTL_I/O
E39   D22#   GTL_I/O
E41   D23#   GTL_I/O
E43   D25#   GTL_I/O
E45   D24#   GTL_I/O
E47   D26#   GTL_I/O
F2   VCCP   POWER
F4   VSS   GND
F6   VCCP   POWER
F8   VSS   GND
F40   VSS   GND
F42   VCCP   POWER
F44   VSS   GND
F46   VCCP   POWER
G1   A22#   GTL_I/O
G3   A24#   GTL_I/O
G5   A27#   GTL_I/O
G7   A26#   GTL_I/O
G9   A31#   GTL_I/O
G39   D27#   GTL_I/O
G41   D29#   GTL_I/O
G43   D30#   GTL_I/O
G45   D28#   GTL_I/O
G47   D31#   GTL_I/O
J1   A19#   GTL_I/O
J3   A21#   GTL_I/O
J5   A20#   GTL_I/O
J7   A23#   GTL_I/O
J9   A28#   GTL_I/O
J39   D32#   GTL_I/O
J41   D35#   GTL_I/O
J43   D38#   GTL_I/O
J45   D33#   GTL_I/O
J47   D34#   GTL_I/O
K2   VSS   GND
K4   VCCP   POWER
K6   VSS   GND
K8   VSS   GND
K40   VSS   GND
K42   VSS   GND
K44   VCCP   POWER
K46   VSS   GND
L1   RESERVED   NC
L3   A16#   GTL_I/O
L5   A15#   GTL_I/O
L7   A18#   GTL_I/O
L9   A25#   GTL_I/O
L39   D37#   GTL_I/O
L41   D40#   GTL_I/O
L43   D43#   GTL_I/O
L45   D36#   GTL_I/O
L47   D39#   GTL_I/O
N1   A12#   GTL_I/O
N3   A14#   GTL_I/O
N5   A11#   GTL_I/O
N7   A13#   GTL_I/O
N9   A17#   GTL_I/O
N39   D44#   GTL_I/O
N41   D45#   GTL_I/O
N43   D47#   GTL_I/O
N45   D42#   GTL_I/O
N47   D41#   GTL_I/O
P2   VCCP   POWER
P4   VSS   GND
P6   VCCP   POWER
P8   VSS   GND
P40   VSS   GND
P42   VCCP   POWER
P44   VSS   GND
P46   VCCP   POWER
Q1   A9#   GTL_I/O
Q3   A7#   GTL_I/O
Q5   A5#   GTL_I/O
Q7   A8#   GTL_I/O
Q9   A10#   GTL_I/O
Q39   D51#   GTL_I/O
Q41   D52#   GTL_I/O
Q43   D49#   GTL_I/O
Q45   D48#   GTL_I/O
Q47   D46#   GTL_I/O
S1   A6#   GTL_I/O
S3   A4#   GTL_I/O
S5   A3#   GTL_I/O
S7   VREF2   NC
S9   AP1#   GTL_I/O
S39   D59#   GTL_I/O
S41   D57#   GTL_I/O
S43   D54#   GTL_I/O
S45   D53#   GTL_I/O
S47   D50#   GTL_I/O
T2   VSS   GND
T4   VCCP   POWER
T6   VSS   GND
T8   VSS   GND
T40   VSS   GND
T42   VSS   GND
T44   VCCP   POWER
T46   VSS   GND
U1   AP0#   GTL_I/O
U3   RSP#   GTL_IN
U5   BPRI#   GTL_IN
U7   BNR#   GTL_I/O
U9   BR3#   GTL_IN
U39   DEP7#   GTL_I/O
U41   VREF6   NC
U43   D60#   GTL_I/O
U45   D56#   GTL_I/O
U47   D55#   GTL_I/O
W1   SMI#   CMOS_IN
W3   BR1#   GTL_IN
W5   REQ4#   GTL_I/O
W7   REQ1#   GTL_I/O
W9   REQ0#   GTL_I/O
W39   DEP2#   GTL_I/O
W41   DEP4#   GTL_I/O
W43   D63#   GTL_I/O
W45   D61#   GTL_I/O
W47   D58#   GTL_I/O
X2   VSS   GND
X4   VSS   GND
X6   VCCP   POWER
X8   VSS   GND
X40   VSS   GND
X42   VCCP   POWER
X44   VSS   GND
X46   VSS   GND
Y1   REQ3#   GTL_I/O
Y3   REQ2#   GTL_I/O
Y5   DEFER#   GTL_IN
Y7   VREF3   NC
Y9   TRDY#   GTL_IN
Y39   PRDY#   GTL_OUT
Y41   RESET#   GTL_IN
Y43   DEP1#   GTL_I/O
Y45   DEP6#   GTL_I/O
Y47   D62#   GTL_I/O
AA1   BR2#   GTL_IN
AA3   DRDY#   GTL_I/O
AA5   DBSY#   GTL_I/O
AA7   HITM#   GTL_I/O
AA9   LOCK#   GTL_I/O
AA39   BPM1#   GTL_I/O
AA41   PICD0#   CMOS_I/O
AA43   PICCLK   CMOS_IN
AA45   PREQ#   CMOS_IN
AA47   DEP5#   GTL_I/O
AB2   VSS   GND
AB4   VCCP   POWER
AB6   VSS   GND
AB8   VSS   GND
AB40   VSS   GND
AB42   VSS   GND
AB44   VCCP   POWER
AB46   VSS   GND
AC1   RESERVED   NC
AC3   HIT#   GTL_I/O
AC5   BR0#   GTL_I/O
AC7   RP#   GTL_I/O
AC9   RS0#   GTL_IN
AC39   BP3#   GTL_I/O
AC41   BPM0#   GTL_I/O
AC43   BINIT#   GTL_I/O
AC45   DEP0#   GTL_I/O
AC47   DEP3#   GTL_I/O
AE1   RESERVED   NC
AE3   ADS#   GTL_I/O
AE5   RS1#   GTL_IN
AE7   RS2#   GTL_IN
AE9   AERR#   GTL_I/O
AE39   TESTHI   NC
AE41   PICD1#   CMOS_I/O
AE43   BP2#   GTL_I/O
AE45   RESERVED   NC
AE47   VREF5   NC
AF2   VSS   GND
AF4   VSS   GND
AF6   VSS   GND
AF8   VSS   GND
AF40   VSS   GND
AF42   VSS   GND
AF44   VSS   GND
AF46   VSS   GND
AG1   VCC5   NC
AG3   UP#   NC
AG5   RESERVED   NC
AG7   POWERGOOD   CMOS_IN
AG9   RESERVED   NC
AG39   RESERVED   NC
AG41   LINT1/NMI   CMOS_IN
AG43   LINT0/INTR   CMOS_IN
AG45   VREF7   NC
AG47   RESERVED   NC
AJ1   VSS   GND
AJ3   VCCP   POWER
AJ5   VSS   GND
AJ7   VCCP   POWER
AJ9   VSS   GND
AJ39   VSS   GND
AJ41   VCCP   POWER
AJ43   VSS   GND
AJ45   VCCP   POWER
AJ47   VSS   GND
AL1   VCCP   POWER
AL3   VSS   GND
AL5   VCCP   POWER
AL7   VSS   GND
AL9   VCCP   POWER
AL39   VCCP   POWER
AL41   VSS   GND
AL43   VCCP   POWER
AL45   VSS   GND
AL47   VCCP   POWER
AN1   VSS   GND
AN3   VCCP   POWER
AN5   VSS   GND
AN7   VCCP   POWER
AN9   VSS   GND
AN39   VSS   GND
AN41   VCCP   POWER
AN43   VSS   GND
AN45   VCCP   POWER
AN47   VSS   GND
AQ1   VCCP   POWER
AQ3   VSS   GND
AQ5   VCCP   POWER
AQ7   VSS   GND
AQ9   VCCP   POWER
AQ39   VCCP   POWER
AQ41   VSS   GND
AQ43   VCCP   POWER
AQ45   VSS   GND
AQ47   VCCP   POWER
AS1   VID0   NC
AS3   VID1   NC
AS5   VID2   NC
AS7   VID3   NC
AS9   RESERVED   NC
AS39   TESTLO   NC
AS41   TESTLO   NC
AS43   TESTLO   NC
AS45   TESTLO   NC
AS47   RESERVED   NC
AU1   VCCS   POWER
AU3   VSS   GND
AU5   VCCS   POWER
AU7   VSS   GND
AU9   VCCS   POWER
AU39   VCCS   POWER
AU41   VSS   GND
AU43   VCCS   POWER
AU45   VSS   GND
AU47   VCCS   POWER
AW1   VSS   GND
AW3   VCCS   POWER
AW5   VSS   GND
AW7   VCCS   POWER
AW9   VSS   GND
AW39   VSS   GND
AW41   VCCS   POWER
AW43   VSS   GND
AW45   VCCS   POWER
AW47   VSS   GND
AY1   VCCS   POWER
AY3   VCCS   POWER
AY5   VCCS   POWER
AY7   VCCS   POWER
AY9   VCCS   POWER
AY39   VCCS   POWER
AY41   VCCS   POWER
AY43   VCCS   POWER
AY45   VCCS   POWER
AY47   VCCS   POWER
BA1   VSS   GND
BA3   VCCS   POWER
BA5   VSS   GND
BA7   VCCS   POWER
BA9   VSS   GND
BA11   RESERVED   NC
BA13   TESTLO   NC
BA15   TESTLO   NC
BA17   VCCP   POWER
BA19   VSS   GND
BA21   VCCP   POWER
BA23   VSS   GND
BA25   VCCP   POWER
BA27   VSS   GND
BA29   VCCP   POWER
BA31   VSS   GND
BA33   TESTLO   NC
BA35   RESERVED   NC
BA37   TESTLO   NC
BA39   VSS   GND
BA41   VCCS   POWER
BA43   VSS   GND
BA45   VCCS   POWER
BA47   VSS   GND
BC1   EMI   POWER
BC3   VSS   GND
BC5   VSS   GND
BC7   VSS   GND
BC9   VSS   GND
BC11   RESERVED   NC
BC13   TESTLO   NC
BC15   TESTLO   NC
BC17   VSS   GND
BC19   VCCS   POWER
BC21   VSS   GND
BC23   VCCS   POWER
BC25   VSS   GND
BC27   VCCS   POWER
BC29   VSS   GND
BC31   VCCS   POWER
BC33   TESTLO   NC
BC35   RESERVED   NC
BC37   TESTLO   NC
BC39   VSS   GND
BC41   VSS   GND
BC43   VSS   GND
BC45   VSS   GND
BC47   EMI   POWER
| Models and submodels in the file (7): GTL_I/O (I/O_open_drain), GTL_OUT (Open_drain), GTL_IN (Input), CMOS_I/O (I/O_open_drain), CMOS_OUT (Open_drain), CMOS_IN (Input), CLKBUFF (Input)
