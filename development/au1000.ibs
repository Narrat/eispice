| IBIS file au1000.ibs
[IBIS ver]   2.1
[File name]   au1000.ibs
[File Rev]   1.1
[Date]   September 30, 2002
[Source]   Advanced Micro Devices
[Notes]   This model assumes an "8ma" driver for the SDCLK* pins.
   Depending on your configuration, you may want to select
   the "4ma" or "12ma" option.
   The 4 crystal pins have been commented-out.
   Please contact technical support at Advanced Micro Devices
   for any & all questions, comments, and/or suggestions
   related to this model.
[Disclaimer] YOU UNDERSTAND THIS INFORMATION HAS NOT BEEN
                 TESTED BY AMD.  THIS INFORMATION MAY CONTAIN
                 TYPOGRAPHICAL ERRORS AND TECHNICAL
                 INACCURACIES.  THIS INFORMATION IS FOR
                 NONCOMMERCIAL MODELING PURPOSES ONLY AND IS
                 PROVIDED AND ACCEPTED "WHERE IS" AND "AS IS" WITH
                 NO WARRANTY, INDEMNITY, OR FURTHER OBLIGATION.
                 AMD DOES NOT WARRANT THAT THIS INFORATION IS
                 WITHOUT DEFECT OR THAT THE OPERATION OF THE
                 TECHNOLOGY WILL BE UNINTERRUPTED OR ERROR-FREE.
                 ALL RISK ARISING OUT OF USE OF THIS INFORMATION
                 REMAINS WITH YOU.  AMD DISCLAIMS ANY AND ALL
                 WARRANTIES RELATING TO THIS INFORMATION, EXPRESS
                 OR IMPLIED, INCLUDING BUT NOT LIMITED TO ANY
                 IMPLIED WARRANTIES OF NONINFRINGEMENT OF THIRD
                 PARTY RIGHTS, FITNESS FOR A PARTICULAR PURPOSE OR
                 MERCHANTABILITY.  TO THE MAXIMAL EXTENT
                 ALLOWABLE BY LAW, AMD WILL NOT BE LIABLE FOR ANY
                 DIRECT, SPECIAL, INCIDENTAL, INDIRECT, INCIDENTAL, OR
                 CONSEQUENTIAL DAMAGES WHATSOEVER EVEN IF AMD
                 HAS BEEN ADVISED OF THE POSSIBILITY OF SUCH
                 DAMAGES.  YOUR USE OF THIS INFORMATION IS
                 CONTINGENT UPON YOUR ACCEPTANCE OF THESE TERMS.
                 AMD RESERVES THE RIGHT TO MODIFY AND/OR
                 WITHDRAW THIS INFORMATION AT ANY TIME FOR ANY OR
                 NO REASON.
[Copyright]   Copyright 2002 Advanced Micro Devices
   All Rights Reserved
|   Component Au1000
[Component]   AU1000
[Manufacturer]   Alchemy Semiconductor Inc.
[Package]
|   324-PIN LBGA
| variable   typ   min   max
R_pkg   3.00m   2.00m   4.00m
L_pkg   8.10nH   6.40nH   9.70nH
C_pkg   0.90pF   0.80pF   1.00pF
[Pin]  signal_name   model_name   R_pin   L_pin   C_pin
A1   STXD   tristate_4
A10   N1RXDV   input
A11   N1TXEN   tristate_4
A12   N2TXCLK   input
A13   N1TXD3   tristate_4
A14   N2RXD0   input
A15   N2RXD1   input
A16   N1MDIO   tristate_4
A17   GP15   tristate_4
A18   N2TXEN   tristate_4
A19   N2TXD3   tristate_4
A2   U2RXD   input
A20   SDD0   tristate_6
A21   SDD3   tristate_6
A22   SDD5   tristate_6
A3   SCLK   tristate_4
A4   I2SDIO   tristate_4
A5   ACSYNC   tristate_4
A6   N1RXD1   input
A7   N1RXD2   input
A8   U0TXD   tristate_4
A9   U2TXD   tristate_4
AA1   RD29   tristate_4
AA10   RD0   tristate_4
AA11   LWAITN   input
AA12   LRDN0   tristate_4
AA13   PWAITN   input
AA14   POEN   tristate_4
AA15   TC3   input
AA16   TC2   input
AA17   GP03   tristate_4
AA18   TC0   input
AA19   GP01   tristate_4
AA2   RD27   tristate_4
AA20   CRSTN   input
AA21   XAGND32   GND
AA22   XPWR32   POWER
AA3   RD25   tristate_4
AA4   RD18   tristate_4
AA5   RD15   tristate_4
AA6   RD12   tristate_4
AA7   RD9   tristate_4
AA8   RD6   tristate_4
AA9   RD4   tristate_4
AB1   RD28   tristate_4
AB10   RD1   tristate_4
AB11   EWAIT   input
AB12   LWRN0   tristate_4
AB13   PCE2N   tristate_4
AB14   PREGN   tristate_4
AB15   PIOS16N   input
AB16   PIOWN   tristate_4
AB17   GP04   tristate_4
AB18   GP02   tristate_4
|AB19   XTI12   ???
AB2   RD24   tristate_4
|AB20   XTO12   ???
|AB21   XTI32   ???
|AB22   XTO32   ???
AB3   RD21   tristate_4
AB4   RD17   tristate_4
AB5   RD14   tristate_4
AB6   RD11   tristate_4
AB7   RD8   tristate_4
AB8   RD5   tristate_4
AB9   RD2   tristate_4
B1   UHCM   tristate_usb
B10   N1RXCLK   input
B11   N1COL   input
B12   N1TXD1   tristate_4
B13   N2CRS   input
B14   N1MDC   tristate_4
B15   GP14   tristate_4
B16   N2RXD3   input
B17   N2TXD0   tristate_4
B18   N2RXDV   input
B19   N2MDC   tristate_4
B2   UDCM   tristate_usb
B20   SDD1   tristate_6
B21   SDD4   tristate_6
B22   SDD6   tristate_6
B3   U1RXD   input
B4   N1TXCLK   input
B5   ACBCLK   input
B6   N1RXD0   input
B7   I2SCLK   tristate_4
B8   I2SWRD   tristate_4
B9   U1TXD   tristate_4
C1   GP12   tristate_4
C10   U3TXD   tristate_4
C11   N1TXD0   tristate_4
C12   N1TXD2   tristate_4
C13   GP13   tristate_4
C14   N2RXD2   input
C15   N2RCLK   input
C16   N2TXD2   tristate_4
C17   N2TXD1   tristate_4
C18   N2COL   input
C19   N2MDIO   tristate_4
C2   TCK   input
C20   SDD2   tristate_6
C21   SDD10   tristate_6
C22   SDD11   tristate_6
C3   UHCP   tristate_usb
C4   SFRM   tristate_4
C5   IRTXD   tristate_4
C6   N1CRS   input
C7   ACRST   tristate_4
C8   ACDO   tristate_4
C9   N1RXD3   input
D1   TDI   input
D10   VDDI   POWER
D11   VDDI   POWER
D12   VDDI   POWER
D13   VDDI   POWER
D14   VDDX   POWER
D15   VDDX   POWER
D16   VDDX   POWER
D17   SDD9   tristate_6
D18   SDD8   tristate_6
D19   SDD7   tristate_6
D2   GP11   tristate_4
D20   SDD12   tristate_6
D21   SDD13   tristate_6
D22   SDD14   tristate_6
D3   U0RXD   input
D4   UDCP   tristate_usb
D5   U3RXD   input
D6   ACDI   input
D7   VDDX   POWER
D8   VDDX   POWER
D9   VDDX   POWER
E1   TDO   output_4
E19   VDDX   POWER
E2   GP09   tristate_4
E20   SDD15   tristate_6
E21   SDD16   tristate_6
E22   SDD17   tristate_6
E3   GP10   tristate_4
E4   IRRXD   input
F1   RCEN2   tristate_4
F19   VDDX   POWER
F2   RCEN3   tristate_4
F20   SDD18   tristate_6
F21   SDD19   tristate_6
F22   SDD20   tristate_6
F3   GP08   tristate_4
F4   SRXD   input
G1   ROEN   tristate_4
G19   VDDX   POWER
G2   RCEN0   tristate_4
G20   SDD21   tristate_6
G21   SDD22   tristate_6
G22   SDD23   tristate_6
G3   RCEN1   tristate_4
G4   VDDX   POWER
H1   RBEN2   tristate_4
H19   VDDI   POWER
H2   RBEN3   tristate_4
H20   SDD24   tristate_6
H21   SDD25   tristate_6
H22   SDD26   tristate_6
H3   RWEN   tristate_4
H4   VDDX   POWER
J1   RAD31   tristate_4
J10   VSS   GND
J11   VSS   GND
J12   VSS   GND
J13   VSS   GND
J14   VSS   GND
J19   VDDI   POWER
J2   RBEN0   tristate_4
J20   SDD27   tristate_6
J21   SDD28   tristate_6
J22   SDD29   tristate_6
J3   RBEN1   tristate_4
J4   VDDX   POWER
J9   VSS   GND
K1   RAD28   tristate_4
K10   VSS   GND
K11   VSS   GND
K12   VSS   GND
K13   VSS   GND
K14   VSS   GND
K19   SDCLK0   tristate_8
K2   RAD29   tristate_4
K20   SDD30   tristate_6
K21   SDD31   tristate_6
K22   SDCSN0   tristate_6
K3   RAD30   tristate_4
K4   VDDI   POWER
K9   VSS   GND
L14   VSS   GND
L1   RAD25   tristate_4
L10   VSS   GND
L11   VSS   GND
L12   VSS   GND
L13   VSS   GND
L19   SDCLK1   tristate_8
L2   RAD27   tristate_4
L20   SDCSN1   tristate_6
L21   SDCSN2   tristate_6
L22   SDWEN   tristate_6
L3   RAD26   tristate_4
L4   VDDI   POWER
L9   VSS   GND
M13   VSS   GND
M14   VSS   GND
M1   RAD23   tristate_4
M10   VSS   GND
M11   VSS   GND
M12   VSS   GND
M19   SDCLK2   tristate_8
M2   RAD24   tristate_4
M20   SDCASN   tristate_6
M21   SDCKE   tristate_6
M22   SDRASN   tristate_6
M3   RAD22   tristate_4
M4   VDDI   POWER
M9   VSS   GND
N14   VSS   GND
N1   RAD21   tristate_4
N10   VSS   GND
N11   VSS   GND
N12   VSS   GND
N13   VSS   GND
N19   VDDI   POWER
N2   RAD20   tristate_4
N20   SDQM2   tristate_6
N21   SDQM1   tristate_6
N22   SDQM0   tristate_6
N3   RAD18   tristate_4
N4   VDDX   POWER
N9   VSS   GND
P13   VSS   GND
P14   VSS   GND
P1   RAD19   tristate_4
P10   VSS   GND
P11   VSS   GND
P12   VSS   GND
P19   VDDX   POWER
P2   RAD17   tristate_4
P20   SDBA1   tristate_6
P21   SDBA0   tristate_6
P22   SDQM3   tristate_6
P3   RAD15   tristate_4
P4   VDDX   POWER
P9   VSS   GND
R1   RAD16   tristate_4
R19   VDDX   POWER
R2   RAD14   tristate_4
R20   SDA2   tristate_6
R21   SDA1   tristate_6
R22   SDA0   tristate_6
R3   RAD10   tristate_4
R4   VDDX   POWER
T1   RAD13   tristate_4
T19   VDDX   POWER
T2   RAD12   tristate_4
T20   SDA5   tristate_6
T21   SDA4   tristate_6
T22   SDA3   tristate_6
T3   RAD7   tristate_4
T4   VDDX   POWER
U1   RAD11   tristate_4
U19   VDDX   POWER
U2   RAD9   tristate_4
U20   SDA8   tristate_6
U21   SDA7   tristate_6
U22   SDA6   tristate_6
U3   RAD4   tristate_4
U4   RAD0   tristate_4
V1   RAD8   tristate_4
V19   SDA12   tristate_6
V2   RAD6   tristate_4
V20   SDA11   tristate_6
V21   SDA10   tristate_6
V22   SDA9   tristate_6
V3   RAD2   tristate_4
V4   RD23   tristate_4
W1   RAD5   tristate_4
W10   LCLK   tristate_6
W11   VDDI   POWER
W12   VDDI   POWER
W13   GP07_F   tristate_4
W14   GP06_F   tristate_4
W15   VDDX   POWER
W16   VDDX   POWER
W17   VDDX   POWER
W18   ROMSIZ   input
W19   ROMSEL   input
W2   RAD3   tristate_4
W20   TMS   input
W21   CVDDXOK   input
W22   CRSTON   tristate_4
W3   RD30   tristate_4
W4   RD22   tristate_4
W5   RD19   tristate_4
W6   VDDX   POWER
W7   VDDX   POWER
W8   VDDX   POWER
W9   VDDI   POWER
Y1   RAD1   tristate_4
Y10   LWRN1   tristate_4
Y11   LRDN1   tristate_4
Y12   PCE1N   tristate_4
Y13   PWEN   tristate_4
Y14   PIORN   tristate_4
Y15   GP05   tristate_4
Y16   TC1   input
Y17   CPWREN   output_4
Y18   GP00   tristate_4
Y19   XAGND12   GND
Y2   RD31   tristate_4
Y20   XPWR12   POWER
Y21   TSTEN   input
Y22   TRSTN   input
Y3   RD26   tristate_4
Y4   RD20   tristate_4
Y5   RD16   tristate_4
Y6   RD13   tristate_4
Y7   RD10   tristate_4
Y8   RD7   tristate_4
Y9   RD3   tristate_4
| Models and submodels in the file (6): input (Input), output_4 (Output), tristate_4 (I/O), tristate_6 (I/O), tristate_8 (I/O), tristate_usb (I/O)
