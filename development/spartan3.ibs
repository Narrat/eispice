| / 7\'7
| \ \   Xilinx Inc.
| / /
| \_\/.\   IBIS Models for Spartan-3
| IBIS file spartan3.ibs created by appending individual files created
| using s2ibis2 version 1.1 North Carolina State University
| Electronics Research Laboratory 1995
[IBIS ver]   2.1
[File name]   spartan3.ibs
[File Rev]   3.4.2
[Date]   06/08/2006
[Source]   Spartan-3 layout and silicon models.
[Notes]   Xilinx Spartan-3 I/O IBIS models.
[Disclaimer] The data in these models is derived from HSPICE simulations
                 using modeling information extracted from the target process.
                 While a great deal of care has been taken to provide
                 information that is accurate, this model is considered
                 PRELIMINARY as it has not been verified by actual silicon
                 measurement.
[Copyright]   Copyright 2004 Xilinx Inc., All rights reserved.
|   Component Spartan-3
[Component]   Spartan-3
[Manufacturer]   Xilinx, Inc.
[Package]
| To accurately model wirebond (FG*) package parasitics, please follow the
| instructions here (along with R_pkg, L_pkg, and C_pkg below):
| To utilize the correct package typ, min, max data in your simulations
| uncomment the desired R_pkg, L_pkg and C_pkg lines corresponding to
| the package of interest.
| Be sure to comment out all the unused lines in this section.
| PQ208
|variable   typ   min   max
|R_pkg   0.2   0.199   0.2
|L_pkg   14.5nH   12.8nH   16.2nH
|C_pkg   1.8pF   1.6pF   2.0pF
| TQ144
|variable   typ   min   max
|R_pkg   0.130   0.123   0.137
|L_pkg   8.3nH   7.5nH   9.2nH
|C_pkg   1.0pF   0.8pF   1.3pF
| FT256
|variable   typ   min   max
|R_pkg   0.141   0.094   0.185
|L_pkg   4.0nH   1.9nH   6.0nH
|C_pkg   0.8pF   0.6pF   0.9pF
| FG456
|variable   typ   min   max
|R_pkg   0.285   0.075   0.494
|L_pkg   5.2nH   2.1nH   8.4nH
|C_pkg   1.3pF   0.7pF   2.0pF
| FG676
|variable   typ   min   max
R_pkg   0.283   0.038   0.529
L_pkg   4.7nH   0.5nH   8.9nH
C_pkg   1.1pF   0.6pF   1.6pF
| FG900
|variable   typ   min   max
|R_pkg   0.303   0.16   0.413
|L_pkg   5.45nH   3.60nH   7.31nH
|C_pkg   1.29pF   0.64pF   2.07pF
| FG1156
|variable   typ   min   max
|R_pkg   1.04   0.009   2.515
|L_pkg   6.74nH   0.713nH   13.8nH
|C_pkg   1.35pF   0.456pF   2.907pF
| CP132
|variable   typ   min   max
|R_pkg   0.142   0.135   0.150
|L_pkg   2.4nH   1.2nH   3.6nH
|C_pkg   0.2pF   0.1pF   0.3pF
[Pin]  signal_name   model_name   R_pin   L_pin   C_pin
|   LVCMOS 1.2V
1   LVCMOS12_F_2mA  LVCMOS12_F_2mA  | fast slew, 2mA drive
2   LVCMOS12_S_2mA  LVCMOS12_S_2mA  | slow slew, 2mA drive
3   LVCMOS12_F_4mA  LVCMOS12_F_4mA  |  fast slew, 4mA drive
4   LVCMOS12_S_4mA  LVCMOS12_S_4mA  | slow slew, 4mA drive
5   LVCMOS12_F_6mA  LVCMOS12_F_6mA  | fast slew, 6mA drive
6   LVCMOS12_S_6mA  LVCMOS12_S_6mA  | slow slew, 6mA drive
|   LVCMOS 1.5V
7   LVCMOS15_F_2mA  LVCMOS15_F_2mA  | fast slew, 2mA drive
8   LVCMOS15_S_2mA  LVCMOS15_S_2mA  | slow slew, 2mA drive
9   LVCMOS15_F_4mA  LVCMOS15_F_4mA  | fast slew, 4mA drive
10   LVCMOS15_S_4mA  LVCMOS15_S_4mA  | slow slew, 4mA drive
11   LVCMOS15_F_6mA  LVCMOS15_F_6mA  | fast slew, 6mA drive
12   LVCMOS15_S_6mA  LVCMOS15_S_6mA  | slow slew, 6mA drive
13   LVCMOS15_F_8mA  LVCMOS15_F_8mA  | fast slew, 8mA drive
14   LVCMOS15_S_8mA  LVCMOS15_S_8mA  | slow slew, 8mA drive
15   LVCMOS15_F_12mA LVCMOS15_F_12mA | fast slew, 12mA drive
16   LVCMOS15_S_12mA LVCMOS15_S_12mA | slow slew, 12mA drive
|   LVCMOS 1.8V
17   LVCMOS18_F_2mA  LVCMOS18_F_2mA  | fast slew, 2mA drive
18   LVCMOS18_S_2mA  LVCMOS18_S_2mA  | slow slew, 2mA drive
19   LVCMOS18_F_4mA  LVCMOS18_F_4mA  | fast slew, 4mA drive
20   LVCMOS18_S_4mA  LVCMOS18_S_4mA  | slow slew, 4mA drive
21   LVCMOS18_F_6mA  LVCMOS18_F_6mA  | fast slew, 6mA drive
22   LVCMOS18_S_6mA  LVCMOS18_S_6mA  | slow slew, 6mA drive
23   LVCMOS18_F_8mA  LVCMOS18_F_8mA  | fast slew, 8mA drive
24   LVCMOS18_S_8mA  LVCMOS18_S_8mA  | slow slew, 8mA drive
25   LVCMOS18_F_12mA LVCMOS18_F_12mA | fast slew, 12mA drive
26   LVCMOS18_S_12mA LVCMOS18_S_12mA | slow slew, 12mA drive
27   LVCMOS18_F_16mA LVCMOS18_F_16mA | fast slew, 16mA drive
28   LVCMOS18_S_16mA LVCMOS18_S_16mA | slow slew, 16mA drive
|   LVCMOS 2.5V
29   LVCMOS25_F_2mA  LVCMOS25_F_2mA  | fast slew, 2mA drive
30   LVCMOS25_S_2mA  LVCMOS25_S_2mA  | slow slew, 2mA drive
31   LVCMOS25_F_4mA  LVCMOS25_F_4mA  | fast slew, 4mA drive
32   LVCMOS25_S_4mA  LVCMOS25_S_4mA  | slow slew, 4mA drive
33   LVCMOS25_F_6mA  LVCMOS25_F_6mA  | fast slew, 6mA drive
34   LVCMOS25_S_6mA  LVCMOS25_S_6mA  | slow slew, 6mA drive
35   LVCMOS25_F_8mA  LVCMOS25_F_8mA  | fast slew, 8mA drive
36   LVCMOS25_S_8mA  LVCMOS25_S_8mA  | slow slew, 8mA drive
37   LVCMOS25_F_12mA LVCMOS25_F_12mA | fast slew, 12mA drive
38   LVCMOS25_S_12mA LVCMOS25_S_12mA | slow slew, 12mA drive
39   LVCMOS25_F_16mA LVCMOS25_F_16mA | fast slew, 16mA drive
40   LVCMOS25_S_16mA LVCMOS25_S_16mA | slow slew, 16mA drive
41   LVCMOS25_F_24mA LVCMOS25_F_24mA | fast slew, 24mA drive
42   LVCMOS25_S_24mA LVCMOS25_S_24mA | slow slew, 24mA drive
|   LVCMOS 3.3V
43   LVCMOS33_F_2mA  LVCMOS33_F_2mA  | fast slew, 2mA drive
44   LVCMOS33_S_2mA  LVCMOS33_S_2mA  | slow slew, 2mA drive
45   LVCMOS33_F_4mA  LVCMOS33_F_4mA  | fast slew, 4mA drive
46   LVCMOS33_S_4mA  LVCMOS33_S_4mA  | slow slew, 4mA drive
47   LVCMOS33_F_6mA  LVCMOS33_F_6mA  | fast slew, 6mA drive
48   LVCMOS33_S_6mA  LVCMOS33_S_6mA  | slow slew, 6mA drive
49   LVCMOS33_F_8mA  LVCMOS33_F_8mA  | fast slew, 8mA drive
50   LVCMOS33_S_8mA  LVCMOS33_S_8mA  | slow slew, 8mA drive
51   LVCMOS33_F_12mA LVCMOS33_F_12mA | fast slew, 12mA drive
52   LVCMOS33_S_12mA LVCMOS33_S_12mA | slow slew, 12mA drive
53   LVCMOS33_F_16mA LVCMOS33_F_16mA | fast slew, 16mA drive
54   LVCMOS33_S_16mA LVCMOS33_S_16mA | slow slew, 16mA drive
55   LVCMOS33_F_24mA LVCMOS33_F_24mA | fast slew, 24mA drive
56   LVCMOS33_S_24mA LVCMOS33_S_24mA | slow slew, 24mA drive
|   LVTTL 3.3V
57   LVTTL_F_2mA LVTTL_F_2mA   | fast slew, 2mA drive
58   LVTTL_S_2mA LVTTL_S_2mA   | slow slew, 2mA drive
59   LVTTL_F_4mA LVTTL_F_4mA   | fast slew, 4mA drive
60   LVTTL_S_4mA LVTTL_S_4mA   | slow slew, 4mA drive
61   LVTTL_F_6mA LVTTL_F_6mA   | fast slew, 6mA drive
62   LVTTL_S_6mA LVTTL_S_6mA   | slow slew, 6mA drive
63   LVTTL_F_8mA LVTTL_F_8mA   | fast slew, 8mA drive
64   LVTTL_S_8mA LVTTL_S_8mA   | slow slew, 8mA drive
65   LVTTL_F_12mA LVTTL_F_12mA   | fast slew, 12mA drive
66   LVTTL_S_12mA LVTTL_S_12mA   | slow slew, 12mA drive
67   LVTTL_F_16mA LVTTL_F_16mA   | fast slew, 16mA drive
68   LVTTL_S_16mA LVTTL_S_16mA   | slow slew, 16mA drive
69   LVTTL_F_24mA LVTTL_F_24mA   | fast slew, 24mA drive
70   LVTTL_S_24mA LVTTL_S_24mA   | slow slew, 24mA drive
|   LVDCI, 50 ohms
71   LVDCI_15_50ohm LVDCI_15_50ohm
72   LVDCI_18_50ohm LVDCI_18_50ohm
73   LVDCI_25_50ohm LVDCI_25_50ohm
74   LVDCI_33_50ohm LVDCI_33_50ohm
|   LVDCI_DV2, 50 ohms (same models as above)
75   LVDCI_15_DV2_50ohm   LVDCI_15_50ohm
76   LVDCI_18_DV2_50ohm   LVDCI_18_50ohm
77   LVDCI_25_DV2_50ohm   LVDCI_25_50ohm
78   LVDCI_33_DV2_50ohm   LVDCI_33_50ohm
|   HSTL 1.5V
79   HSTL_I_15   HSTL_I_15
80   HSTL_I_15_DCI_in   HSTL_I_15_DCI_in
81   HSTL_III_15   HSTL_III_15
82   HSTL_III_15_DCI_in   HSTL_III_15_DCI_in
|   HSTL 1.8V
83   HSTL_I_18   HSTL_I_18
84   HSTL_I_18_DCI_in   HSTL_I_18_DCI_in
85   HSTL_II_18   HSTL_II_18
86   HSTL_II_18_DCI_in   HSTL_II_18_DCI_in
87   HSTL_II_18_DCI_out   HSTL_II_18_DCI_out
88   HSTL_III_18   HSTL_III_18
89   HSTL_III_18_DCI_in   HSTL_III_18_DCI_in
|   SSTL 1.8V
90   SSTL18_I   SSTL18_I
91   SSTL18_I_DCI_in   SSTL18_I_DCI_in
92   SSTL18   SSTL18 | Based on JESD8-15A standard.
|92   SSTL18_I_DCI_out   SSTL18_I_DCI_out
|   SSTL 2.5V
93   SSTL2_I   SSTL2_I
94   SSTL2_I_DCI_in   SSTL2_I_DCI_in
|95   SSTL2_I_DCI_out   SSTL2_I_DCI_out
96   SSTL2_II   SSTL2_II | Based on JESD8-9B standard.
97   SSTL2_II_DCI_in   SSTL2_II_DCI_in
98   SSTL2_II_DCI_out   SSTL2_II_DCI_out
99   PCI33_3   PCI33_3
99B   PCI66_3   PCI66_3
|   GTL, GTLP
100   GTL   GTL
101   GTLP   GTLP
102   GTL_DCI_out   GTL_DCI_out
103   GTL_DCI_in   GTL_DCI_in
104   GTLP_DCI_out   GTLP_DCI_out
105   GTLP_DCI_in   GTLP_DCI_in
|   Differential models
106P   LVDS_25P   LVDS_25
106N   LVDS_25N   LVDS_25
|   LVDS_25_DCI is input only; also use for LVDSEXT_25_DCI
|107   LVDS_25_DCI   LVDS_25_DCI
|108P   ULVDS_25P   ULVDS_25
|108N   ULVDS_25N   ULVDS_25
109P   LVPECL_25P   LVPECL_25
109N   LVPECL_25N   LVPECL_25
110P   RSDS_25P   RSDS_25
110N   RSDS_25N   RSDS_25
111P   BLVDS_25P   BLVDS_25
111N   BLVDS_25N   BLVDS_25
112P   LDT_25P   LDT_25
112N   LDT_25N   LDT_25
113P   LVDSEXT_25P   LVDSEXT_25
113N   LVDSEXT_25N   LVDSEXT_25
|   High-Speed LVDCI 1.8V
|113   HSLVDCI_18   HSLVDCI_18
|   LVDS w/ DCI termination
|114   LVDS_25_DCI_in  LVDS_25_DCI_in
114   LVDS_25_DCI_in  SSTL2_I_DCI_in
[Diff Pin]   inv_pin   vdiff   tdelay_typ   tdelay_min   tdelay_max
106P   106N   350mV   0   0   0
109P   109N   850mV   0   0   0
110P   110N   200mV   0   0   0
111P   111N   350mV   0   0   0
112P   112N   600mV   0   0   0
113P   113N   540mV   0   0   0
| Models and submodels in the file (107): LVCMOS25_F_12mA (I/O), LVCMOS25_F_16mA (I/O), LVCMOS25_F_24mA (I/O), LVCMOS25_F_2mA (I/O), LVCMOS25_F_4mA (I/O), LVCMOS25_F_6mA (I/O), LVCMOS25_F_8mA (I/O), LVCMOS33_F_12mA (I/O), LVCMOS33_F_16mA (I/O), LVCMOS33_F_24mA (I/O), LVCMOS33_F_2mA (I/O), LVCMOS33_F_4mA (I/O), LVCMOS33_F_6mA (I/O), LVCMOS33_F_8mA (I/O), LVTTL_F_12mA (I/O), LVTTL_F_16mA (I/O), LVTTL_F_24mA (I/O), LVTTL_F_2mA (I/O), LVTTL_F_4mA (I/O), LVTTL_F_6mA (I/O), LVTTL_F_8mA (I/O), LVCMOS18_F_12mA (I/O), LVCMOS18_F_16mA (I/O), LVCMOS18_F_2mA (I/O), LVCMOS18_F_4mA (I/O), LVCMOS18_F_6mA (I/O), LVCMOS18_F_8mA (I/O), LVCMOS15_F_12mA (I/O), LVCMOS15_F_2mA (I/O), LVCMOS15_F_4mA (I/O), LVCMOS15_F_6mA (I/O), LVCMOS15_F_8mA (I/O), SSTL18_I (I/O), SSTL18 (I/O), SSTL2_I (I/O), SSTL2_II (I/O), HSTL_III_15 (I/O), HSTL_III_18 (I/O), HSTL_II_18 (I/O), HSTL_I_15 (I/O), HSTL_I_18 (I/O), GTL (I/O_open_drain), GTLP (I/O_open_drain), LVDSEXT_25 (I/O), LVDS_25 (I/O), RSDS_25 (I/O), LVDCI_15_50ohm (I/O), LVDCI_18_50ohm (I/O), LVDCI_25_50ohm (I/O), LVDCI_33_50ohm (I/O), LVPECL_25 (I/O), BLVDS_25 (I/O), PCI33_3 (I/O), PCI66_3 (I/O), SSTL2_I_DCI_in (Input), SSTL18_I_DCI_in (Input), HSTL_I_15_DCI_in (Input), HSTL_III_15_DCI_in (Input), HSTL_I_18_DCI_in (Input), HSTL_III_18_DCI_in (Input), LVCMOS12_F_4mA (I/O), LVCMOS12_F_6mA (I/O), LVCMOS12_F_2mA (I/O), GTL_DCI_out (Output), GTLP_DCI_out (Output), LDT_25 (I/O), SSTL2_II_DCI_out (Output), GTL_DCI_in (Input), GTLP_DCI_in (Input), SSTL2_II_DCI_in (Input), HSTL_II_18_DCI_in (Input), HSTL_II_18_DCI_out (Output), LVCMOS12_S_2mA (I/O), LVCMOS12_S_4mA (I/O), LVCMOS12_S_6mA (I/O), LVCMOS15_S_12mA (I/O), LVCMOS15_S_2mA (I/O), LVCMOS15_S_4mA (I/O), LVCMOS15_S_6mA (I/O), LVCMOS15_S_8mA (I/O)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
